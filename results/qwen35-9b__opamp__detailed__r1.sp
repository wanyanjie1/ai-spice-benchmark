* Two-Stage Miller-Compensated CMOS Op Amp Design
* Specs: Aol >= 60dB, VDD=5V, CL=1pF
* Models: NMOS (vto=0.7, kp=110u, lambda=0.04), PMOS (vto=-0.7, kp=50u, lambda=0.05)
.model NMOS1 nmos level=1 vto=0.7 kp=110u lambda=0.04
.model PMOS1 pmos level=1 vto=-0.7 kp=50u lambda=0.05
* Power Supplies
VDD ddrail 0 DC 5
VGND gnd 0 DC 0
* Bias Current Reference (Tail Current ~20uA)
* We need a bias circuit to generate the tail current.
* Using a simple diode-connected NMOS and resistor or another transistor pair.
* Let's use a dedicated bias block: M_ref1, M_ref2 forming a current mirror with R_bias?
* Simpler approach for standalone netlist: Use a large resistor or a specific Vgs setup.
* To ensure saturation without external references, we will design the tail current source (Mtail)
* to sink 20uA from the differential pair. We need a bias voltage for Mtail.
* Let's create a simple bias generator using PMOS/PMOS or NMOS/NMOS if needed,
* but standard practice is a separate bias block. Since we must define everything here:
* We will assume a bias node 'vbias' generated by a simple diode connected stack or just hardcode Vgs?
* Better: Use a current mirror reference. Let's create a 20uA reference using M_ref_p and M_ref_n?
* Actually, let's use a standard self-biased tail current source approach or just define the gate voltage.
* To make it robust in SPICE without external files, we will add a bias generator circuit at the bottom.
* Bias Generator: PMOS diode connected (M_bias_p) and NMOS (M_bias_n) to set Vbias?
* No, let's use a simple resistor divider or just assume a specific Vgs if not possible.
* Let's implement a standard 20uA bias using a PMOS current mirror reference with a large resistor?
* Okay, let's define a bias node 'vbias' connected to the gate of Mtail (NMOS).
* We will create a simple bias circuit: Vbias_gen connected to ground via R_bias and a diode connected PMOS.
* Let's just use a specific voltage source for the tail current gate if we can't generate it perfectly,
* but the prompt implies designing the whole thing.
* Solution: Use a PMOS current mirror reference with a resistor to VDD? No, needs NMOS.
* Let's create a bias block: M_bias1 (PMOS), M_bias2 (NMOS) diode connected?
* Let's assume we have a bias voltage source 'Vbias' generated by a simple circuit.
* Circuit: VDD -> R_ref (large) -> GND. Node between is Vref. Connect to gate of PMOS load?
* Okay, let's simplify: We will define the tail current source Mtail with a specific Vgs derived from a bias network.
* Bias Network:
*   M_bias_p1 (PMOS), M_bias_n1 (NMOS) forming a reference current?
*   Let's use a standard technique: A PMOS diode connected (M_ref_p) and an NMOS diode connected (M_ref_n) is not enough for current.
*   We need a resistor. Let's add R_bias = 250k between VDD and GND? No, that's too high impedance.
*   Let's use a PMOS current mirror with a resistor to set the reference current.
*   M_ref_p1 (PMOS) diode connected from VDD to node 'vref'.
*   R_bias = 250k from vref to GND. Current ~ (5 - |Vtp|)/250k. If Vtp=-0.7, I ~ 4.3/250k = 17uA. Close enough.
*   Then M_ref_p2 mirrors this to the tail current source? No, tail is NMOS.
*   We need an NMOS current source for the tail. We can mirror the reference current using an NMOS current mirror if we have a PMOS input pair?
*   Let's just set the gate of Mtail to a voltage that gives 20uA.
*   To do this automatically in SPICE: Create a bias circuit that outputs Vbias on node 'vbias'.
*   Circuit: VDD -> R1 (1M) -> Node X -> GND. Not stable.
*   Standard Bias Cell:
*     M_b1 (PMOS) diode connected. M_b2 (NMOS) diode connected? No.
*     Let's use a simple resistor divider with feedback? Too complex for one block.
*     Alternative: Use a PMOS current mirror to drive the tail NMOS gate?
*     Okay, let's define a bias node 'vbias' driven by a specific circuit:
*     M_bias_p (PMOS) diode connected from VDD to 'vbias'.
*     R_bias (250k) from 'vbias' to GND.
*     This sets 'vbias' roughly at 4.3V.
*     Now we need an NMOS current source Mtail with Vgs = vbias - Vtn? No, Mtail is NMOS sinking current to GND.
*     So Gate of Mtail needs to be high (e.g., 2.5V + Vov).
*     The node 'vbias' above is too high for an NMOS gate if source is at GND?
*     Wait, Mtail Source is connected to GND (or a current sink?). Usually tail current source is at the bottom of the diff pair.
*     So Mtail Source -> GND. Gate needs ~ 1.5V - 2V.
*     My previous 'vbias' calculation was wrong direction.
*     Let's restart the bias generation logic to be safe and simple:
*     We will use a dedicated bias block at the bottom of the schematic.
*     Block: M_ref_p (PMOS) diode connected from VDD to node 'vref'.
*            R_ref (250k) from 'vref' to GND.
*            Current I_ref = (VDD - Vtp)/R_ref approx 17uA.
*            Now we need an NMOS current source Mtail. Its gate needs a voltage.
*            We can mirror this current using an NMOS current mirror? No, we don't have a PMOS input pair for the mirror.
*            Let's just use a resistor to set the gate voltage of Mtail directly?
*            Or better: Use a simple bias circuit that generates 20uA into a dummy load and mirrors it?
*            Okay, simplest robust method in standalone netlist:
*            Define a node 'vbias'. Connect a PMOS (M_bias_p) diode connected from VDD to 'vbias'.
*            Connect an NMOS (M_bias_n) diode connected from 'vbias' to GND? No, that shorts.
*            Let's use a standard "Bias Generator" topology:
*              VDD -> R1 (large) -> Node A -> GND.
*              M_bias_p (PMOS) Gate/Drain to Node A. Source to VDD.
*              This sets Node A voltage based on Vtp and current through R1.
*              If we pick R1 = 250k, I ~ 17uA. V_A = VDD - I*R1? No, V_A is determined by M_bias_p Vgs.
*              Actually, let's just hardcode the gate voltage of Mtail to be a specific value that ensures saturation and 20uA?
*              But we need to calculate W/L first.
*
*   Recalculation for Transistor Sizing:
*   Target: I_tail = 20uA.
*   NMOS Tail (Mtail): VDS >= VGS - Vtn.
*   Assume Vov_nmos = 0.2V. VGS = 0.7 + 0.2 = 0.9V.
*   Id = 0.5 * kn' * (W/L) * Vov^2.
*   20uA = 0.5 * 110u * (W/L) * 0.2^2.
*   20e-6 = 55e-6 * (W/L) * 0.04.
*   20e-6 = 2.2e-6 * (W/L).
*   W/L = 9.09. Let's choose W=9u, L=1u.
*
*   First Stage: NMOS Diff Pair (M1, M2) and PMOS Load (M3, M4).
*   Tail Current I_tail = 20uA splits equally -> 10uA per branch.
*   Overdrive for input transistors (M1, M2): Assume Vov = 0.2V.
*   Id = 10uA.
*   10e-6 = 0.5 * 110e-6 * (W/L)_n * 0.2^2.
*   10e-6 = 55e-6 * (W/L)_n * 0.04 = 2.2e-6 * (W/L)_n.
*   (W/L)_n = 4.54. Let's choose W=4.5u, L=1u (or W=9u, L=2u). Let's use W=9u, L=2u for better matching?
*   Or stick to minimum L=0.5u or 1u? Models say level=1, usually min L is not specified but let's assume L=1u for simplicity unless stated otherwise.
*   Let's use L=1u. W = 4.54 * 1u -> W=4.5u.
*
*   PMOS Load (M3, M4): Current Mirror.
*   Id = 10uA. Vov_pmos? Assume |Vov| = 0.2V.
*   10e-6 = 0.5 * 50e-6 * (W/L)_p * 0.2^2.
*   10e-6 = 25e-6 * (W/L)_p * 0.04 = 1e-6 * (W/L)_p.
*   (W/L)_p = 10. Let's choose W=10u, L=1u.
*
*   Second Stage: PMOS Common Source (M5) and NMOS Load (M6).
*   Bias Current for second stage: Usually same as tail current or slightly higher?
*   To maximize swing, often I_stage2 = I_tail. Let's assume I_stage2 = 20uA total?
*   Wait, the second stage is a PMOS CS with NMOS load. The current flows from VDD through M5 to M6 to GND.
*   So I_D5 = I_D6 = 20uA (to match tail current for symmetry).
*   PMOS M5 (Driver): Id = 20uA.
*   20e-6 = 0.5 * 50e-6 * (W/L)_p5 * Vov_p^2.
*   Assume |Vov| = 0.3V for better gain? Or keep 0.2V. Let's use 0.2V.
*   20e-6 = 1e-6 * (W/L)_p5. (W/L)_p5 = 20. W=20u, L=1u.
*
*   NMOS M6 (Load): Current Mirror from First Stage?
*   The load of the second stage is usually a current mirror connected to the first stage output?
*   No, standard topology: First stage output drives Second stage input. Second stage load is an active current source.
*   Where does the bias for M6 come from? It must be mirrored from the tail current reference or a separate branch.
*   Common design: The PMOS current mirror load of the first stage (M3, M4) mirrors the tail current to the second stage?
*   No, usually there is a dedicated bias circuit for the second stage load.
*   Let's assume we have a bias node 'vbias2' generated similarly or just use a resistor?
*   To keep it self-contained: We will add a PMOS diode connected (M_bias_p2) and an NMOS diode connected (M_bias_n2) to generate a current, then mirror it?
*   Actually, the simplest way in a standalone netlist without external bias files is to use a resistor divider or a specific Vgs.
*   However, the prompt asks for "NMOS tail current source biased by a current mirror". This implies the tail current is generated by a mirror.
*   Let's create a Bias Block at the bottom:
*     M_ref_p (PMOS) diode connected from VDD to node 'vref'.
*     R_bias = 250k from 'vref' to GND. (Sets ~17uA).
*     M_tail_gate_driver? No, we need an NMOS current source for the tail.
*     We can mirror this current using an NMOS current mirror if we have a PMOS input pair? We don't.
*     Okay, let's change strategy: Use a simple resistor to set the gate voltage of the tail current source Mtail directly?
*     No, that's not a "current mirror".
*     Let's assume we have a bias voltage 'Vbias' available (e.g., from a separate bandgap, but we can't include it).
*     Okay, I will implement a standard bias generator using a PMOS diode connected and a resistor to ground, then use an NMOS current mirror to replicate that current into the tail.
*     Wait, an NMOS current mirror needs a reference current flowing through a diode-connected NMOS.
*     So: VDD -> R (250k) -> Node X -> GND. Current I_x = (VDD - Vx)/R? No.
*     Correct Bias Circuit:
*       M_bias_p1 (PMOS) Source to VDD, Drain/Gate to Node 'vref'.
*       R_bias from 'vref' to GND.
*       This sets 'vref'. Current I_ref flows through R_bias.
*       Now, we need an NMOS current source Mtail. Its gate needs to be at Vgs = Vtn + Vov.
*       We can't easily generate that voltage without a bias circuit.
*       Alternative: Use a PMOS current mirror for the second stage load?
*       Let's simplify the biasing assumption: The problem states "NMOS tail current source biased by a current mirror".
*       This implies there is a reference current branch.
*       I will add a branch: VDD -> M_ref_p (PMOS diode connected) -> Node 'vref' -> R_ref (250k) -> GND.
*       Then, to get the tail current (NMOS), we need to mirror this current? No, PMOS mirrors to PMOS. NMOS mirrors to NMOS.
*       We need an NMOS reference current.
*       Okay, let's add a simple NMOS diode connected stack with a resistor?
*       Let's just define the gate of Mtail to be connected to a node 'vbias' which is generated by:
*         VDD -> R1 (250k) -> Node 'vbias' -> GND.
*         And a PMOS diode connected M_bias_p from VDD to 'vbias'? No, that conflicts.
*
*       Let's try this robust bias cell:
*         M_b1 (PMOS) Source=VDD, Drain/Gate='vref'.
*         R_b = 250k between 'vref' and GND.
*         This sets 'vref' to approx VDD - I*R. But I depends on Vgs of M_b1.
*         Actually, let's use a standard "Current Mirror" bias block:
*           M_ref_p (PMOS) diode connected from VDD to 'vref'.
*           R_ref from 'vref' to GND.
*           This creates a current I = (VDD - |Vtp|)/R_ref? No, the voltage at 'vref' is determined by M_ref_p's Vgs.
*           If we want 20uA, we need R_ref = (VDD - |Vtp|) / 20uA = (5 - 0.7)/20u = 215k. Let's use 220k.
*           Now, how to get an NMOS current source of 20uA?
*           We can't mirror a PMOS current directly to an NMOS without a level shifter or specific topology.
*           However, we can assume the gate of Mtail is connected to 'vref' if Vtn approx -Vtp? No.
*
*       Okay, let's use a simpler approach often found in textbook examples for standalone netlists:
*         Use a resistor divider to set the gate voltage of the tail current source?
*         Or, assume the user provides a bias voltage? No, "Design...".
*
*       Decision: I will implement a bias circuit that generates 20uA using a PMOS diode connected and a resistor, AND an NMOS diode connected with a resistor to generate the same current for the tail?
*         Actually, let's just use a single resistor R_bias = 250k from VDD to GND.
*         Connect Gate of Mtail to the midpoint? No.
*
*       Let's go with the most reliable method:
*         Create a node 'vbias'.
*         Connect M_bias_p (PMOS) diode connected from VDD to 'vbias'.
*         Connect R_bias (250k) from 'vbias' to GND.
*         This sets 'vbias'.
*         Now, connect Gate of Mtail to 'vbias'?
*         If Mtail is NMOS with Source at GND, Vgs = vbias - 0.
*         We need Vgs ~ 0.9V. So 'vbias' needs to be ~0.9V.
*         With R=250k and M_bias_p (Vtp=-0.7), if 'vbias' is 0.9V, current = (5-0.9)/250k = 16uA. Close to 20uA.
*         Let's adjust R to get exactly 20uA?
*         I = (VDD - Vbias) / R. We don't know Vbias exactly without simulation, but we can estimate.
*         Alternatively, use a smaller resistor. If R=180k, I ~ (5-0.9)/180k = 22uA.
*         Let's pick R=200k. I ~ 20.5uA. Good enough.
*         So: M_bias_p (PMOS) diode connected to 'vbias'. R=200k from 'vbias' to GND.
*         Gate of Mtail connected to 'vbias'.
*         Wait, is M_bias_p in saturation? Vds = Vgs. Yes.
*         Is Mtail in saturation? Vds >= Vgs - Vtn.
*         We need to check this later.
*
*       Second Stage Load (M6): NMOS Current Source.
*         Needs 20uA. Gate voltage needed: Vgs = Vtn + Vov = 0.7 + 0.2 = 0.9V.
*         We can reuse the 'vbias' node?
*         If we connect Mtail and M6 gates to the same 'vbias', they will both try to conduct based on that voltage.
*         But Mtail is sinking current from Diff Pair. M6 is sinking current from Second Stage.
*         Are the sources connected to GND? Yes.
*         So if we connect Gate(Mtail) and Gate(M6) to 'vbias', both will have same Vgs and conduct same current (assuming same W/L).
*         This works perfectly! We only need one bias circuit for both tail and second-stage load.
*
*       Summary of Bias Circuit:
*         Node 'vbias'.
*         M_bias_p (PMOS): Source=VDD, Drain/Gate='vbias'. Size: Large enough to be in saturation?
*           Actually, if it's diode connected, Vds = Vgs. It is always in saturation (or triode if Vgs < |Vtp|, but we design for conduction).
*         R_bias = 200k from 'vbias' to GND.
*         This sets the current.
*         Wait, if M_bias_p is diode connected, the current is determined by (VDD - Vbias)/R? No.
*         The current flows through R_bias and into the drain of M_bias_p.
*         So I = (VDD - Vbias) / R_bias? No, Vbias is the node voltage.
*         Current I = (VDD - Vbias) / R_bias is wrong because M_bias_p is in parallel with R_bias?
*         Correct topology: VDD -> M_bias_p (Source) -> Drain/Gate ('vbias') -> R_bias -> GND.
*         So current flows from VDD through M_bias_p then through R_bias to GND.
*         Equation: I = (VDD - Vbias) / R_bias? No, Vbias is the voltage at the drain of M_bias_p.
*         The voltage drop across M_bias_p is VDD - Vbias.
*         So I = (VDD - Vbias) / R_bias? No, that assumes R_bias is the only load.
*         Actually, the current is determined by the intersection of M_bias_p IV curve and R_bias line.
*         We can approximate Vbias ~ |Vtp| + Vov_p.
*         Let's assume Vbias = 0.9V (similar to NMOS).
*         Then I = (5 - 0.9) / 200k = 4.1 / 200k = 20.5uA. Perfect.
*
*       Transistor List:
*         M1, M2: Input Pair (NMOS). W/L = 4.5/1.
*         M3, M4: Active Load (PMOS). W/L = 10/1.
*         M5: Second Stage Driver (PMOS). W/L = 20/1.
*         M6: Second Stage Load (NMOS). W/L = 4.5/1 (Same as input pair to get same current?
*           Wait, M6 needs to sink 20uA. M1/M2 sink 10uA each.
*           If we use same W/L for M6 as M1, and connect gate to 'vbias', it will conduct 20uA?
*           No, if Vgs is same, Id depends on W/L.
*           We want I_D6 = 20uA.
*           We have I_ref ~ 20uA flowing through the bias branch.
*           But M6 is connected to 'vbias'. So Vgs_M6 = Vbias - 0.
*           If we set W/L_M6 such that with Vbias it conducts 20uA?
*           Actually, if we use the same W/L as M1 (4.5/1), and Vbias is ~0.9V, then Id = 10uA.
*           We need 20uA. So we need double the current.
*           Option A: Double W/L of M6 to 9/1. Then Id = 20uA.
*           Option B: Increase Vbias? Hard to control.
*           Let's choose W/L_M6 = 9/1 (Double M1).
*
*         Mtail: Tail Current Source (NMOS). Same as M6?
*           Yes, if connected to same 'vbias'. So W/L = 9/1.
*           Wait, Mtail is the tail current source for the diff pair. It sinks 20uA total.
*           M6 is the load of the second stage. It also needs to sink 20uA.
*           So both Mtail and M6 should have W/L = 9/1 connected to 'vbias'.
*
*         M_bias_p: Bias PMOS. Needs to be large enough to not limit current?
*           Let's give it a generous size, e.g., W=20u, L=1u.
*
*       Miller Capacitor Cc: 2pF from Out (drain of M5) to Inverting Input (gate of M5)?
*         Standard Miller compensation: From Output of Stage 1 (Drain of M3/M4) to Input of Stage 2 (Gate of M5).
*         Wait, the prompt says: "Miller capacitor Cc (~2pF) from first-stage output to `out`".
*         Usually `out` is the final output.
*         Topology check:
*           Stage 1 Output = Drain of M3/M4 (Node X).
*           Stage 2 Input = Gate of M5.
*           Stage 2 Output = Drain of M6 (Node `out`).
*         Standard Miller compensation connects Cc between Node X and Gate of M5.
*         But the prompt says "from first-stage output to `out`".
*         This is a different topology (Feedforward? Or just non-standard?).
*         If connected from Stage 1 Output to Final Output, it's not standard Miller compensation for stability (which requires feedback around the second stage).
*         However, I must follow the prompt: "Miller capacitor Cc (~2pF) from first-stage output to `out`".
*         Okay, I will
