* Two-Stage CMOS Operational Amplifier

* Power Supply
Vdd vdd 0 DC 5

* Input AC Source (Non-Inverting Input node 'in')
Vin in 0 DC 2.5 AC 1

* DC Feedback Loop for Operating Point Self-Biasing
Rdc out in_m 1G
Cac in_m 0 1F

* Bias Reference Circuit
Rbias vdd vbias_n 100k
Mbias vbias_n vbias_n 0 0 NMOS W=10u L=2u

* First Stage: Differential Pair with Active Load
M5 tail vbias_n 0 0 NMOS W=10u L=2u
M1 n1 in tail 0 NMOS W=20u L=2u
M2 n2 in_m tail 0 NMOS W=20u L=2u
M3 n1 n2 vdd vdd PMOS W=20u L=2u
M4 n2 n2 vdd vdd PMOS W=20u L=2u

* Second Stage: Common-Source Amplifier
M6 out n1 vdd vdd PMOS W=50u L=2u
M7 out vbias_n 0 0 NMOS W=25u L=2u

* Miller Compensation Network
Cc n1 cc_int 3p
Rc cc_int out 1k

* MOSFET Models
.model NMOS NMOS (LEVEL=1 VTO=0.7 KP=100U LAMBDA=0.010 GAMMA=0.4)
.model PMOS PMOS (LEVEL=1 VTO=-0.7 KP=40U LAMBDA=0.015 GAMMA=0.4)

* Analysis Command

.control
set wr_singlescale
ac dec 50 1 1e9
wrdata gemini__opamp__simple__r1.dat vdb(out)
quit
.endc
.end
