* First-order Passive RC Low-Pass Filter Design
* Specification: fc = 1 kHz, Passband Gain = 0 dB
* Topology: V1 (AC 1) -> R -> out -> C -> GND
* Calculation: fc = 1/(2*pi*R*C) => R = 1/(2*pi*fc*C)
* Given C = 100nF, fc = 1000 Hz
* R = 1 / (2 * pi * 1000 * 100e-9) ≈ 1591.55 Ohms
* Using standard resistor value: 1.6kOhm (approximate for simulation)
V1 in 0 AC 1
R1 in out 1.6k
C1 out 0 100nF
.control
set wr_singlescale
ac dec 50 1 1e9
wrdata qwen35-9b__rc_lpf__detailed__r1.dat vdb(out)
quit
.endc
.end
